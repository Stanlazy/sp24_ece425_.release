procedure(nmosplz()
	let( ( cv )
		cv = geGetEditCellView()
		dbCreateRect(cv list("pwell" "drawing") list(0:0 0.37:0.2))
		dbCreateRect(cv list("active" "drawing") list(0.055:0.055 0.315:0.145))
		dbCreateRect(cv list("nimplant" "drawing") list(0.055:0.055 0.315:0.145))
		dbCreateRect(cv list("metal1" "drawing") list(0.06:0.025 0.125:0.175))
		dbCreateRect(cv list("metal1" "drawing") list(0.245:0.025 0.31:0.175))
		dbCreateRect(cv list("poly" "drawing") list(0.16:0.0025 0.21:0.1975))
		dbCreateRect(cv list("contact" "drawing") list(0.06:0.06 0.125:0.14))
		dbCreateRect(cv list("contact" "drawing") list(0.245:0.06 0.31:0.14))
	)
);

procedure(pmosplz()
	let( ( cv )
		cv = geGetEditCellView()
		dbCreateRect(cv list("nwell" "drawing") list(0:0 0.37:0.2))
		dbCreateRect(cv list("active" "drawing") list(0.055:0.055 0.315:0.145))
		dbCreateRect(cv list("pimplant" "drawing") list(0.055:0.055 0.315:0.145))
		dbCreateRect(cv list("metal1" "drawing") list(0.06:0.025 0.125:0.175))
		dbCreateRect(cv list("metal1" "drawing") list(0.245:0.025 0.31:0.175))
		dbCreateRect(cv list("poly" "drawing") list(0.16:0.0025 0.21:0.1975))
		dbCreateRect(cv list("contact" "drawing") list(0.06:0.06 0.125:0.14))
		dbCreateRect(cv list("contact" "drawing") list(0.245:0.06 0.31:0.14))
	)
);
